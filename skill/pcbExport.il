; PcbToJson v0.8 Core baseline (non-destructive)
; One entry, one JSON file. This is a collector BASELINE, not validated full film geometry.
; Execute: load("pcbExport.il")  pcbExport()
;
; Use SKILL %L serialization for strings (quoted SKILL literals); test non-ASCII,
; quote/control-character escaping with the provided Python validator.
procedure(pjt08Quote(value)
  if(value then sprintf(nil "%L" value) else "null")
)
procedure(pjt08Num(value)
  if(numberp(value) then sprintf(nil "%.8f" value) else "null")
)
procedure(pjt08XY(point)
  if(point && listp(point) && numberp(car(point)) && numberp(cadr(point)) then
    sprintf(nil "[%s,%s]" pjt08Num(car(point)) pjt08Num(cadr(point)))
  else "null")
)
procedure(pjt08Pair(points)
  if(points && listp(points) && cadr(points) then
    sprintf(nil "[%s,%s]" pjt08XY(car(points)) pjt08XY(cadr(points)))
  else "null")
)
procedure(pjt08Comma(port, count)
  when(count > 0 fprintf(port ",\n"))
)
procedure(pjt08Segment(port, seg, layer, netName, sourceKind, objIdx, segIdx)
  let((isArc mid radius cw)
    isArc = (seg->objType == "arc")
    mid = nil
    radius = nil
    cw = nil
    when(isArc
      mid = seg->xy
      radius = seg->radius
      cw = seg->isClockwise
    )
    fprintf(port "{\"type\":%s,\"layer\":%s,\"net\":%s,\"source_type\":%s,\"source_object\":%d,\"segment_index\":%d,\"endpoints\":%s,\"width\":%s,\"center\":%s,\"radius\":%s,\"clockwise\":%s}"
      pjt08Quote(seg->objType) pjt08Quote(layer) pjt08Quote(netName)
      pjt08Quote(sourceKind) objIdx segIdx pjt08Pair(seg->startEnd)
      pjt08Num(seg->width) pjt08XY(mid) pjt08Num(radius)
      if(isArc then if(cw then "true" else "false") else "null"))
  )
)

; Text object as placed in Allegro (NOT inferred from component center).
; Font metrics are advisory: the viewer uses substitute fonts, so the shape of glyphs is unverified.
procedure(pjt09TextRecord(port obj refdes sourceName)
  let((tb info textHeight textWidth strokeWidth blockName)
    tb = nil info = nil textHeight = nil textWidth = nil strokeWidth = nil
    when(obj->textBlock
      blockName = strcat("paramTextBlock:" obj->textBlock)
      info = errset(axlGetParam(blockName) t)
      when(info tb = car(info))
    )
    when(tb
      textHeight = tb->height
      textWidth = tb->width
      strokeWidth = tb->photoWidth
    )
    fprintf(port "{\"layer\":%s,\"refdes\":%s,\"source\":%s,\"text\":%s,\"position\":%s,\"rotation\":%s,\"mirrored\":%s,\"justify\":%s,\"text_block\":%s,\"height\":%s,\"width\":%s,\"stroke_width\":%s}"
      pjt08Quote(obj->layer) pjt08Quote(refdes) pjt08Quote(sourceName)
      pjt08Quote(obj->text) pjt08XY(obj->xy) pjt08Num(obj->rotation)
      if(obj->isMirrored then "true" else "false")
      pjt08Quote(obj->justify) pjt08Quote(obj->textBlock)
      pjt08Num(textHeight) pjt08Num(textWidth) pjt08Num(strokeWidth))
  )
)
procedure(pjt09WantedTextLayer(layerName)
  layerName && (rexMatchp("^REF DES/" layerName) ||
    rexMatchp("^PIN NUMBER/" layerName) ||
    rexMatchp("^PACKAGE GEOMETRY/SILKSCREEN_" layerName) ||
    rexMatchp("^PACKAGE GEOMETRY/ASSEMBLY_" layerName) ||
    rexMatchp("^BOARD GEOMETRY/SILKSCREEN_" layerName))
)

; Read only documented padstack drill-definition fields. Null means unknown,
; not zero. The geometry is a preview, not a verified manufacturing drill path.
procedure(pjt092DrillJson(obj)
  let((def dia w h off fig)
    def = nil dia = nil w = nil h = nil off = nil fig = nil
    when(obj def = obj->definition)
    when(def
      dia = def->drillDiameter
      w = def->drillSizeWidth
      h = def->drillSizeHeight
      off = def->drillOffset
      fig = def->drillFigureName
    )
    sprintf(nil "{\"diameter\":%s,\"size\":[%s,%s],\"offset\":%s,\"figure\":%s,\"geometry_verified\":false}"
      pjt08Num(dia) pjt08Num(w) pjt08Num(h) pjt08XY(off) pjt08Quote(fig))
  )
)

; v0.9.3 diagnostic Padstack geometry. These records are NOT manufacturing polarity ops.
; Return nil for no/NULL/zero-size pad; catch Allegro query failures without aborting export.
procedure(pjt093PadDiagnostic(obj ownerType ownerId netName layerName kindName)
  let((answer geom bounds dx dy figure)
    geom = nil
    answer = errset(axlDBGetPad(obj layerName kindName) t)
    when(answer geom = car(answer))
    when(geom && geom->bBox
      bounds = geom->bBox
      dx = xCoord(cadr(bounds)) - xCoord(car(bounds))
      dy = yCoord(cadr(bounds)) - yCoord(car(bounds))
      figure = geom->figureName
      when(numberp(dx) && numberp(dy) && dx > 0 && dy > 0 && figure && figure != "NULL"
        return(sprintf(nil "{\"owner_type\":%s,\"owner_id\":%s,\"net\":%s,\"layer\":%s,\"kind\":%s,\"position\":%s,\"rotation\":%s,\"shape\":%s,\"size\":[%s,%s],\"bbox_raw\":%s,\"geometry_verified\":false}"
          pjt08Quote(ownerType) pjt08Quote(ownerId) pjt08Quote(netName)
          pjt08Quote(layerName) pjt08Quote(kindName) pjt08XY(obj->xy)
          pjt08Num(obj->rotation) pjt08Quote(figure) pjt08Num(dx) pjt08Num(dy) pjt08Pair(bounds)))
      )
    )
    nil
  )
)

procedure(pcbExport()
  let((dsn port log layers layerNo sub sym comp compdef props prop value package refdes
      side net branch child seg netName nLayers nComps nSeg nShapes nVias nPins
      nText nShapeSeg nBoardSeg nPkgSeg i j shape void outline layerName
      nShapeVoidSeg nNoNetShapes shapeQuery shapeFound shapeName
      pin physIdx pinNo pinNet pad padQuery padLayer padBox padWidth padHeight
      padFig nPhysicalPins nPadRecords nPadErrors nPinsWithoutNumber pinName pinRotation nTextGraphics nTextFromSymbols nTextFromDesign textObj
      viaObj viaSeen viaCount viaPadCount viaNullPadCount viaDupCount viaPadNum viaPadLayer viaBox viaWidth viaHeight viaQuery viaFig viaNet viaOrd
      diagIdx diagPinIdx diagViaIdx diagSeen diagKind diagLayer diagJson diagNet diagAntiCount diagThermalCount diagSkipped diagOwner)
    dsn = axlDBGetDesign()
    unless(dsn error("pcbExport: open a PCB design first.\n"))
    layers = axlGetParam("paramLayerGroup:ETCH")->groupMembers
    unless(layers error("pcbExport: cannot query paramLayerGroup:ETCH\n"))
    port = outfile("pcb_core_v0_8.json")
    log = outfile("pcb_core_v0_8_report.txt")
    nLayers = 0 nComps = 0 nSeg = 0 nShapes = 0 nVias = 0 nPins = 0
    nText = 0 nShapeSeg = 0 nBoardSeg = 0 nPkgSeg = 0 nShapeVoidSeg = 0
    nNoNetShapes = 0
    nPhysicalPins = 0 nPadRecords = 0 nPadErrors = 0 nPinsWithoutNumber = 0
    fprintf(port "{\n\"schema_version\":\"0.8.0-core-preview\",\n")
    fprintf(port "\"source\":{\"application\":\"Cadence Allegro\",\"units\":%s,\"stackup_order_verified\":false},\n"
      pjt08Quote(car(axlDBGetDesignUnits())))
    fprintf(port "\"layers\":[\n")
    foreach(sub layers
      pjt08Comma(port nLayers)
      nLayers = nLayers + 1
      fprintf(port "{\"id\":\"L%02d\",\"allegro_layer\":%s,\"route_index\":%d,\"film_subclasses\":[%s,%s,%s]}"
        nLayers pjt08Quote(strcat("ETCH/" sub)) nLayers
        pjt08Quote(strcat("ETCH/" sub)) pjt08Quote(strcat("PIN/" sub))
        pjt08Quote(strcat("VIA CLASS/" sub)))
    )
    fprintf(port "\n],\n\"components\":[\n")
    foreach(sym dsn->symbols
      refdes = sym->refdes
      when(refdes
        pjt08Comma(port nComps)
        nComps = nComps + 1
        comp = sym->component
        package = nil compdef = nil value = nil
        when(comp package = comp->package compdef = comp->compdef)
        props = nil
        when(compdef props = axlDBGetProperties(compdef))
        foreach(prop props when(car(prop) == 'VALUE value = cadr(prop)))
        side = if(sym->isMirrored then "bottom" else "top")
        fprintf(port "{\"refdes\":%s,\"footprint\":%s,\"value\":%s,\"side\":%s,\"position\":%s,\"rotation\":%s}"
          pjt08Quote(refdes) pjt08Quote(package) pjt08Quote(value)
          pjt08Quote(side) pjt08XY(sym->xy) pjt08Num(sym->rotation))
      )
    )
    ; Physical PIN records are distinct from per-layer pad graphics.
    ; Internal ordinal is unique within this export, even if Allegro pin->number is nil.
    fprintf(port "\n],\n\"pins\":[\n")
    foreach(sym dsn->symbols
      refdes = sym->refdes
      when(refdes
        foreach(pin sym->pins
          pjt08Comma(port nPhysicalPins)
          nPhysicalPins = nPhysicalPins + 1
          pinNo = pin->number
          unless(pinNo nPinsWithoutNumber = nPinsWithoutNumber + 1)
          pinNet = nil
          when(pin->net pinNet = pin->net->name)
          fprintf(port "{\"id\":\"PIN%06d\",\"refdes\":%s,\"number\":%s,\"padstack\":%s,\"net\":%s,\"position\":%s,\"rotation\":%s,\"through\":%s,\"drill\":%s}"
            nPhysicalPins pjt08Quote(refdes) pjt08Quote(pinNo) pjt08Quote(pin->name)
            pjt08Quote(pinNet) pjt08XY(pin->xy) pjt08Num(pin->rotation)
            if(pin->isThrough then "true" else "false") pjt092DrillJson(pin))
        )
      )
    )
    fprintf(port "\n],\n\"pads\":[\n")
    physIdx = 0
    foreach(sym dsn->symbols
      refdes = sym->refdes
      when(refdes
        foreach(pin sym->pins
          physIdx = physIdx + 1
          pinNet = nil
          when(pin->net pinNet = pin->net->name)
          foreach(sub layers
            padLayer = strcat("ETCH/" sub)
            pad = nil
            padQuery = errset(axlDBGetPad(pin padLayer "REGULAR") t)
            when(padQuery pad = car(padQuery))
            if(pad && pad->bBox then
              padBox = pad->bBox
              padWidth = xCoord(cadr(padBox)) - xCoord(car(padBox))
              padHeight = yCoord(cadr(padBox)) - yCoord(car(padBox))
              padFig = pad->figureName
              pjt08Comma(port nPadRecords)
              nPadRecords = nPadRecords + 1
              fprintf(port "{\"pin_id\":\"PIN%06d\",\"refdes\":%s,\"layer\":%s,\"net\":%s,\"position\":%s,\"rotation\":%s,\"shape\":%s,\"size\":[%s,%s],\"bbox_raw\":%s,\"geometry_verified\":false}"
                physIdx pjt08Quote(refdes) pjt08Quote(padLayer) pjt08Quote(pinNet)
                pjt08XY(pin->xy) pjt08Num(pin->rotation) pjt08Quote(padFig)
                pjt08Num(padWidth) pjt08Num(padHeight) pjt08Pair(padBox))
            else
              nPadErrors = nPadErrors + 1
            )
          )
        )
      )
    )
    ; Via objects belong to a net branch, not to a component PIN.
    ; Use a DBID-keyed table to emit each physical via only once.
    ; Keep only positive-size REGULAR pads; drill geometry is NOT inferred.
    fprintf(port "\n],\n\"vias\":[\n")
    viaSeen = makeTable("pjt09ViaSeen" nil)
    viaCount = 0 viaPadCount = 0 viaNullPadCount = 0 viaDupCount = 0
    foreach(net dsn->nets
      viaNet = net->name
      foreach(branch net->branches
        foreach(viaObj branch->children
          when(viaObj->objType == "via"
            if(viaSeen[viaObj] then
              viaDupCount = viaDupCount + 1
            else
              viaSeen[viaObj] = t
              pjt08Comma(port viaCount)
              viaCount = viaCount + 1
              fprintf(port "{\"id\":\"VIA%06d\",\"net\":%s,\"position\":%s,\"padstack\":%s,\"rotation\":%s,\"drill\":%s,\"pads\":["
                viaCount pjt08Quote(viaNet) pjt08XY(viaObj->xy)
                pjt08Quote(viaObj->name) pjt08Num(viaObj->rotation) pjt092DrillJson(viaObj))
              viaPadNum = 0
              foreach(sub layers
                viaPadLayer = strcat("ETCH/" sub)
                pad = nil
                viaQuery = errset(axlDBGetPad(viaObj viaPadLayer "REGULAR") t)
                when(viaQuery pad = car(viaQuery))
                if(pad && pad->bBox then
                  viaBox = pad->bBox
                  viaWidth = xCoord(cadr(viaBox)) - xCoord(car(viaBox))
                  viaHeight = yCoord(cadr(viaBox)) - yCoord(car(viaBox))
                  viaFig = pad->figureName
                  if(numberp(viaWidth) && numberp(viaHeight) && viaWidth > 0 && viaHeight > 0 && viaFig && viaFig != "NULL" then
                    pjt08Comma(port viaPadNum)
                    viaPadNum = viaPadNum + 1
                    viaPadCount = viaPadCount + 1
                    fprintf(port "{\"layer\":%s,\"shape\":%s,\"size\":[%s,%s],\"bbox_raw\":%s,\"geometry_verified\":false}"
                      pjt08Quote(viaPadLayer) pjt08Quote(viaFig) pjt08Num(viaWidth) pjt08Num(viaHeight) pjt08Pair(viaBox))
                  else
                    viaNullPadCount = viaNullPadCount + 1
                  )
                else
                  viaNullPadCount = viaNullPadCount + 1
                )
              )
              fprintf(port "]}")
            )
          )
        )
      )
    )
    ; Diagnostic shapes are physically associated with PIN/VIA, never with a
    ; particular film polarity. Keep separate from actual REGULAR copper pads.
    fprintf(port "\n],\n\"padstack_diagnostics\":[\n")
    diagIdx = 0 diagPinIdx = 0 diagViaIdx = 0
    diagAntiCount = 0 diagThermalCount = 0 diagSkipped = 0
    foreach(sym dsn->symbols
      when(sym->refdes
        foreach(pin sym->pins
          diagPinIdx = diagPinIdx + 1
          diagOwner = sprintf(nil "PIN%06d" diagPinIdx)
          diagNet = nil
          when(pin->net diagNet = pin->net->name)
          foreach(sub layers
            diagLayer = strcat("ETCH/" sub)
            foreach(diagKind '("ANTI" "THERMAL")
              diagJson = pjt093PadDiagnostic(pin "pin" diagOwner diagNet diagLayer diagKind)
              if(diagJson then
                pjt08Comma(port diagIdx)
                fprintf(port "%s" diagJson)
                diagIdx = diagIdx + 1
                if(diagKind == "ANTI" then diagAntiCount = diagAntiCount + 1 else diagThermalCount = diagThermalCount + 1)
              else diagSkipped = diagSkipped + 1)
            )
          )
        )
      )
    )
    diagSeen = makeTable("pjt093DiagnosticSeen" nil)
    foreach(net dsn->nets
      diagNet = net->name
      foreach(branch net->branches
        foreach(viaObj branch->children
          when(viaObj->objType == "via" && !diagSeen[viaObj]
            diagSeen[viaObj] = t
            diagViaIdx = diagViaIdx + 1
            diagOwner = sprintf(nil "VIA%06d" diagViaIdx)
            foreach(sub layers
              diagLayer = strcat("ETCH/" sub)
              foreach(diagKind '("ANTI" "THERMAL")
                diagJson = pjt093PadDiagnostic(viaObj "via" diagOwner diagNet diagLayer diagKind)
                if(diagJson then
                  pjt08Comma(port diagIdx)
                  fprintf(port "%s" diagJson)
                  diagIdx = diagIdx + 1
                  if(diagKind == "ANTI" then diagAntiCount = diagAntiCount + 1 else diagThermalCount = diagThermalCount + 1)
                else diagSkipped = diagSkipped + 1)
              )
            )
          )
        )
      )
    )
    fprintf(port "\n],\n\"tracks\":[\n")
    i = 0
    foreach(net dsn->nets
      netName = net->name
      foreach(branch net->branches
        foreach(child branch->children
          when(child->objType == "path"
            j = 0
            foreach(seg child->segments
              pjt08Comma(port nSeg)
              nSeg = nSeg + 1 j = j + 1
              pjt08Segment(port seg child->layer netName "path" i j)
            )
          )
          i = i + 1
        )
      )
    )
    fprintf(port "\n],\n\"zones\":[\n")
    ; Every shape has net/layer and separate outer/void rings.
    ; Coverage is still net-branch associated only; standalone copper is NOT proven.
    i = 0
    foreach(net dsn->nets
      foreach(branch net->branches
        foreach(child branch->children
          when(child->objType == "shape"
            pjt08Comma(port nShapes)
            nShapes = nShapes + 1
            fprintf(port "{\"layer\":%s,\"net\":%s,\"rings\":["
              pjt08Quote(child->layer) pjt08Quote(net->name))
            j = 0
            foreach(seg child->segments
              pjt08Comma(port j) j = j + 1 nShapeSeg = nShapeSeg + 1
              pjt08Segment(port seg child->layer net->name "shape_outer" i j)
            )
            fprintf(port "],\"voids\":[")
            let((k)
              k = 0
              foreach(void child->voids
                pjt08Comma(port k) k = k + 1
                fprintf(port "[")
                j = 0
                foreach(seg void->segments
                  pjt08Comma(port j) j = j + 1 nShapeVoidSeg = nShapeVoidSeg + 1
                  pjt08Segment(port seg child->layer net->name "shape_void" i j)
                )
                fprintf(port "]")
              )
            )
            fprintf(port "]}")
          )
          i = i + 1
        )
      )
    )
    fprintf(port "\n],\n\"board\":{\"outline\":[")
    outline = dsn->designOutline
    when(outline
      j = 0
      foreach(seg outline->segments
        pjt08Comma(port nBoardSeg) nBoardSeg = nBoardSeg + 1 j = j + 1
        pjt08Segment(port seg "BOARD GEOMETRY/DESIGN_OUTLINE" nil "board_outline" 0 j)
      )
    )
    fprintf(port "]},\n\"package_graphics\":[\n")
    ; Collect assembly / silkscreen / place_bound paths and shapes; text is counted but not serialized.
    foreach(sym dsn->symbols
      refdes = sym->refdes
      when(refdes
        foreach(child sym->children
          layerName = child->layer
          when(layerName &&
            (rexMatchp("^PACKAGE GEOMETRY/ASSEMBLY_" layerName) ||
             rexMatchp("^PACKAGE GEOMETRY/SILKSCREEN_" layerName) ||
             rexMatchp("^PACKAGE GEOMETRY/PLACE_BOUND_" layerName))
            if(child->objType == "text" then
              nText = nText + 1
            else
              when(child->objType == "path" || child->objType == "shape"
                j = 0
                foreach(seg child->segments
                  pjt08Comma(port nPkgSeg) nPkgSeg = nPkgSeg + 1 j = j + 1
                  fprintf(port "{\"refdes\":%s,\"layer\":%s,\"geometry\":" pjt08Quote(refdes) pjt08Quote(layerName))
                  pjt08Segment(port seg layerName nil "package" 0 j)
                  fprintf(port "}")
                )
              )
            )
          )
        )
      )
    )
    fprintf(port "\n],\n\"text_graphics\":[\n")
    nTextGraphics = 0 nTextFromSymbols = 0 nTextFromDesign = 0
    ; Symbol-scoped text is preferred: it permits exact reference ownership.
    foreach(sym dsn->symbols
      refdes = sym->refdes
      when(refdes
        foreach(textObj sym->children
          when(textObj->objType == "text" && pjt09WantedTextLayer(textObj->layer)
            pjt08Comma(port nTextGraphics)
            pjt09TextRecord(port textObj refdes "symbol_child")
            nTextGraphics = nTextGraphics + 1
            nTextFromSymbols = nTextFromSymbols + 1
          )
        )
      )
    )
    ; Design-level text includes independent labels outside component symbols.
    ; There may be references also reachable through symbols: validate geometrical overlap.
    foreach(textObj dsn->text
      when(textObj->objType == "text" && pjt09WantedTextLayer(textObj->layer)
        pjt08Comma(port nTextGraphics)
        pjt09TextRecord(port textObj nil "design_text")
        nTextGraphics = nTextGraphics + 1
        nTextFromDesign = nTextFromDesign + 1
      )
    )
    fprintf(port "\n],\n")
    ; Diagnostics are intentionally honest: all unimplemented categories are UNKNOWN, not EMPTY.
    fprintf(port "\"extraction_status\":{\"layers\":\"collected_unverified_order\",\"tracks\":\"net_branch_only\",\"components\":\"collected\",\"zones\":\"net_branch_only_unverified\",\"board_outline\":\"designOutline_only\",\"package_graphics\":\"path_shape_only\",\"package_text\":\"collected_text_objects_unverified\",\"refdes_text\":\"collected_text_objects_unverified\",\"pins\":\"collected_number_unverified\",\"padstacks\":\"regular_pad_bbox_approx_unverified\",\"vias\":\"net_branch_regular_pad_bbox_unverified\",\"soldermask\":\"not_exported\",\"pastemask\":\"not_exported\",\"drill\":\"padstack_definition_unverified\",\"standalone_copper\":\"not_verified\"}\n}")
    fprintf(log "PcbToJson v0.8 core preview\n")
    fprintf(log "layers=%d\ncomponents=%d\ntracks_segments=%d\nnet_associated_shapes=%d\nshape_outer_segments=%d\nshape_void_segments=%d\nboard_outline_segments=%d\npackage_segments=%d\npackage_text_not_exported=%d\n"
      nLayers nComps nSeg nShapes nShapeSeg nShapeVoidSeg nBoardSeg nPkgSeg nText)
    fprintf(log "text_graphics=%d\ntext_from_symbols=%d\ntext_from_design=%d\n" nTextGraphics nTextFromSymbols nTextFromDesign)
    fprintf(log "physical_pins=%d\npad_layer_records=%d\npin_number_missing=%d\npad_query_missing_or_error=%d\n" nPhysicalPins nPadRecords nPinsWithoutNumber nPadErrors)
    ; Read-only coverage audit. This does NOT assume that the database-wide query
    ; and net-branch traversal identify the same object universe.
    ; axlDBGetShapes is queried by each explicit ETCH subclass.
    fprintf(log "SHAPE_COVERAGE: database-wide subclass query; compare manually with net-associated count.\n")
    foreach(sub layers
      shapeName = strcat("ETCH/" sub)
      shapeQuery = errset(axlDBGetShapes(shapeName) t)
      if(shapeQuery then
        shapeFound = car(shapeQuery)
        fprintf(log "SHAPE_COVERAGE layer=%s query_count=%d\n" shapeName length(shapeFound))
      else
        fprintf(log "SHAPE_COVERAGE layer=%s query_failed=true\n" shapeName)
      )
    )
    fprintf(log "padstack_diagnostics=%d\npadstack_anti_valid=%d\npadstack_thermal_valid=%d\npadstack_diagnostic_null_or_invalid=%d\n" diagIdx diagAntiCount diagThermalCount diagSkipped)
    fprintf(log "drill_data_source=padstack_definition_unverified\n")
    fprintf(log "vias=%d\nvia_valid_pad_layer_records=%d\nvia_null_or_invalid_pad_layers=%d\nvia_duplicate_branch_references=%d\n" viaCount viaPadCount viaNullPadCount viaDupCount)
    fprintf(log "BLOCKED: ANTI/THERMAL BBOX diagnostic only; no film polarity, clearance or thermal spoke synthesis.\n")
    fprintf(log "BLOCKED: net-associated shapes need count/geometry comparison to Allegro.\n")
    fprintf(log "BLOCKED: standalone copper, mask/paste NOT exported; drill definition collected unverified; via REGULAR geometry only as BBOX preview; textual geometry collected but not validated against Allegro; pad geometry is BBOX PREVIEW ONLY.\n")
    close(port) close(log)
    printf("pcbExport v0.8 preview: %d layers, %d segments, %d net shapes\n" nLayers nSeg nShapes)
  )
)
axlCmdRegister("pcbExport" 'pcbExport)
